* SPICE3 file created from system.ext - technology: sky130A

.subckt system Dout CLK Anlg_in VCCD ENB GND Vbs_12 VCCA Vbs_34
C0 VCCA vco_0/vco_ring_osc_0/p[3] 4.16595f
C1 vco_0/vco_ring_osc_0/pn[2] vco_0/vco_ring_osc_0/pn[3] 2.563558f
C2 vco_0/p[4] vco_0/vco_ring_osc_0/p[0] 2.297207f
C3 dco_0/Isup dco_0/p_osc 2.865048f
C4 vco_0/vco_ring_osc_0/pn[0] vco_0/vco_ring_osc_0/pn[4] 2.563558f
C5 vco_0/vco_ring_osc_0/pn[1] vco_0/vco_ring_osc_0/pn[2] 2.590521f
C6 VCCA vco_0/vco_ring_osc_0/pn[4] 3.216743f
C7 vco_0/vco_ring_osc_0/p[2] vco_0/vco_ring_osc_0/p[1] 2.296917f
C8 vco_0/p[4] VCCA 4.115379f
C9 vco_0/vco_ring_osc_0/pn[2] VCCA 3.222176f
C10 vco_0/p[4] vco_0/vco_ring_osc_0/p[3] 2.296917f
C11 vco_0/vco_ring_osc_0/p[1] vco_0/vco_ring_osc_0/p[0] 2.296917f
C12 VCCA vco_0/vco_ring_osc_0/p[2] 5.227906f
C13 dco_0/dco_ring_osc_0/p[1] dco_0/Isup 2.560124f
C14 dco_0/dco_ring_osc_0/p[0] dco_0/Isup 2.557879f
C15 dco_0/Isup dco_0/dco_ring_osc_0/p[2] 3.689101f
C16 vco_0/vco_ring_osc_0/pn[1] vco_0/vco_ring_osc_0/p[1] 2.817913f
C17 vco_0/p[4] vco_0/vco_ring_osc_0/pn[4] 3.589511f
C18 vco_0/vco_ring_osc_0/p[2] vco_0/vco_ring_osc_0/p[3] 2.297206f
C19 vco_0/vco_ring_osc_0/pn[0] vco_0/vco_ring_osc_0/p[0] 2.817914f
C20 VCCA vco_0/vco_ring_osc_0/pn[3] 3.133489f
C21 VCCA vco_0/vco_ring_osc_0/p[0] 4.165949f
C22 dco_0/dco_ring_osc_0/p[3] dco_0/Isup 2.565691f
C23 VCCA vco_0/vco_ring_osc_0/p[1] 4.166379f
C24 dco_0/ro_div2 VCCD 2.83143f
C25 vco_0/vco_ring_osc_0/pn[1] vco_0/vco_ring_osc_0/pn[0] 2.563558f
C26 vco_0/vco_ring_osc_0/p[3] vco_0/vco_ring_osc_0/pn[3] 2.817914f
C27 vco_0/vco_ring_osc_0/pn[1] VCCA 3.192856f
C28 VCCA vco_0/vco_ring_osc_0/pn[0] 3.220588f
C29 vco_0/vco_ring_osc_0/pn[2] vco_0/vco_ring_osc_0/p[2] 3.383091f
C30 vco_0/vco_ring_osc_0/pn[3] vco_0/vco_ring_osc_0/pn[4] 2.563558f
Xcount_0 vco_0/p[4] ENB qz_0/FBack D1 GND VCCD count
Xdco_0 VCCD VCCA D1 ENB Vbs_12 Vbs_34 p_dco GND dco
Xcount_1 p_dco ENB qz_0/FBack qz_0/D GND VCCD count
Xqz_0 CLK Dout qz_0/FBack qz_0/D GND VCCD qz
Xvco_0 VCCD ENB vco_0/p[4] Anlg_in VCCA VCCA GND vco
C31 VCCA GND 0.131825p
C32 vco_0/vco_ring_osc_0/p[3] GND 5.839946f
C33 vco_0/vco_ring_osc_0/pn[3] GND 7.125296f
C34 vco_0/vco_ring_osc_0/VGND GND 21.748072f
C35 vco_0/p[4] GND 10.39066f
C36 vco_0/vco_ring_osc_0/pn[4] GND 11.142102f
C37 vco_0/vco_ring_osc_0/p[2] GND 7.276832f
C38 vco_0/vco_ring_osc_0/pn[2] GND 8.351643f
C39 vco_0/vco_ring_osc_0/p[1] GND 5.839947f
C40 vco_0/vco_ring_osc_0/pn[1] GND 7.099289f
C41 vco_0/vco_ring_osc_0/p[0] GND 5.886267f
C42 vco_0/vco_ring_osc_0/pn[0] GND 7.25434f
C43 qz_0/D GND 4.024829f
C44 qz_0/FBack GND 17.701258f
C45 count_1/SetBi GND 3.191061f
C46 ENB GND 23.391851f
C47 Vbs_12 GND 3.24752f
C48 dco_0/dco_idac_0/D1_M4 GND 6.010999f **FLOATING
C49 dco_0/dco_idac_0/B_M2 GND 2.038646f **FLOATING
C50 dco_0/dco_idac_0/D_M7 GND 2.126267f **FLOATING
C51 dco_0/dco_idac_0/G_M5 GND 2.60848f
C52 dco_0/dco_idac_0/G_M7 GND 2.180161f
C53 D1 GND 2.869859f
C54 dco_0/dco_ring_osc_0/pn[3] GND 3.842829f
C55 dco_0/dco_ring_osc_0/p[3] GND 2.511793f
C56 dco_0/dco_ring_osc_0/pn[4] GND 6.390505f
C57 dco_0/p_osc GND 7.112562f
C58 dco_0/dco_ring_osc_0/pn[2] GND 4.464279f
C59 dco_0/Isup GND 49.33119f
C60 dco_0/dco_ring_osc_0/p[2] GND 3.392114f
C61 dco_0/dco_ring_osc_0/pn[1] GND 3.823762f
C62 dco_0/dco_ring_osc_0/p[1] GND 2.511596f
C63 dco_0/dco_ring_osc_0/pn[0] GND 3.855207f
C64 dco_0/dco_ring_osc_0/p[0] GND 2.511309f
C65 VCCD GND 81.72057f
C66 p_dco GND 2.492806f
C67 dco_0/dco_freq_1/D GND 3.366808f
C68 dco_0/ro_div2 GND 3.696161f
C69 dco_0/dco_freq_1/Q_N GND 2.985495f
C70 dco_0/dco_freq_0/D GND 3.341408f
C71 dco_0/dco_freq_0/Q_N GND 2.971666f
C72 count_0/SetBi GND 3.173411f
.ends
