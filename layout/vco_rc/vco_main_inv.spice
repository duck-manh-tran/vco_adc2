* SPICE3 file created from vco_main_inv.ext - technology: sky130A

.option scale=10m

.subckt vco_main_inv A VPWR VGND Y VCCA GND
X0 VGND A Y GND sky130_fd_pr__nfet_01v8 ad=64n pd=1.76m as=32n ps=0.88m w=400 l=365
X1 Y A VGND GND sky130_fd_pr__nfet_01v8 ad=32n pd=0.88m as=64n ps=1.76m w=400 l=365
X2 Y A VPWR VCCA sky130_fd_pr__pfet_01v8 ad=40n pd=1.08m as=80n ps=2.16m w=500 l=365
X3 VPWR A Y VCCA sky130_fd_pr__pfet_01v8 ad=80n pd=2.16m as=40n ps=1.08m w=500 l=365
C0 A GND 3.60778f
C1 VCCA GND 6.74505f
.ends
