* SPICE3 file created from vco_cc_inv.ext - technology: sky130A

.subckt vco_cc_inv inp inn VPWR VGND outp outn VCCA GND
C0 outp inp 2.296917f
C1 outn outp 2.114311f
C2 outn inn 2.563558f
Xvco_aux_inv_0 outp VPWR VGND outn VCCA GND vco_aux_inv
Xvco_aux_inv_1 outn VPWR VGND outp VCCA GND vco_aux_inv
Xvco_main_inv_0 inp VPWR VGND outp VCCA GND vco_main_inv
Xvco_main_inv_1 inn VPWR VGND outn VCCA GND vco_main_inv
C3 VCCA GND 22.660961f
C4 inn GND 5.013029f
C5 VGND GND 3.611396f
C6 outp GND 2.355758f
C7 VPWR GND 2.506192f
C8 inp GND 3.742834f
C9 outn GND 2.189102f
.ends
