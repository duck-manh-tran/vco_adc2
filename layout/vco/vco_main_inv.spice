* SPICE3 file created from vco_main_inv.ext - technology: sky130A

.subckt vco_main_inv A VPWR VGND Y VCCA GND
X0 VPWR.t1 A.t0 Y.t0 VCCA.t1 sky130_fd_pr__pfet_01v8 ad=2 pd=10.8 as=1 ps=5.4 w=5 l=3.65
X1 Y.t3 A.t1 VGND.t1 GND.t1 sky130_fd_pr__nfet_01v8 ad=0.8 pd=4.4 as=1.6 ps=8.8 w=4 l=3.65
X2 VGND.t0 A.t2 Y.t1 GND.t0 sky130_fd_pr__nfet_01v8 ad=1.6 pd=8.8 as=0.8 ps=4.4 w=4 l=3.65
X3 Y.t2 A.t3 VPWR.t0 VCCA.t0 sky130_fd_pr__pfet_01v8 ad=1 pd=5.4 as=2 ps=10.8 w=5 l=3.65
R0 A.n10 A.n5 154.782
R1 A.n17 A.n16 152
R2 A.n11 A.n6 152
R3 A.n13 A.n12 152
R4 A.n12 A.n4 139.321
R5 A.n18 A.n17 96.7759
R6 A.n4 A.n2 33.0142
R7 A.n9 A.n7 33.0142
R8 A.n4 A.n3 26.4115
R9 A.n9 A.n8 26.4115
R10 A.n11 A.n10 18.3624
R11 A.n12 A.n11 18.3624
R12 A.n10 A.n9 17.2148
R13 A.n19 A.n18 13.3645
R14 A.n14 A.n13 9.3005
R15 A.n16 A.n15 9.3005
R16 A.n1 A.n0 9.3005
R17 A.n16 A.n1 7.87742
R18 A.n13 A.n6 7.87742
R19 A.n18 A.n1 3.62653
R20 A.n14 A.n5 3.36202
R21 A.n6 A.n5 2.75975
R22 A.n17 A.n4 1.14812
R23 A.n15 A.n14 0.558192
R24 A.n15 A.n0 0.0774231
R25 A.n19 A.n0 0.0774231
R26 A A.n19 0.0389615
R27 A.n6 A.n3 154.782
R28 A.n13 A.n12 152
R29 A.n7 A.n4 152
R30 A.n9 A.n8 152
R31 A.n8 A.n2 139.321
R32 A.n14 A.n13 96.7759
R33 A.n2 A.t3 33.0142
R34 A.n5 A.t0 33.0142
R35 A.n2 A.t1 26.4115
R36 A.n5 A.t2 26.4115
R37 A.n7 A.n6 18.3624
R38 A.n8 A.n7 18.3624
R39 A.n6 A.n5 17.2148
R40 A.n15 A.n14 13.3645
R41 A.n10 A.n9 9.3005
R42 A.n12 A.n11 9.3005
R43 A.n1 A.n0 9.3005
R44 A.n12 A.n1 7.87742
R45 A.n9 A.n4 7.87742
R46 A.n14 A.n1 3.62653
R47 A.n10 A.n3 3.36202
R48 A.n4 A.n3 2.75975
R49 A.n13 A.n2 1.14812
R50 A.n11 A.n10 0.558192
R51 A.n11 A.n0 0.0774231
R52 A.n15 A.n0 0.0774231
R53 A A.n15 0.0389615
R54 Y.n2 Y.n1 174.363
R55 Y Y.n2 42.4398
R56 Y.n1 Y.t0 7.8805
R57 Y.n1 Y.t2 7.8805
R58 Y.n2 Y.n0 7.16508
R59 Y.n0 Y.t1 6.0005
R60 Y.n0 Y.t3 6.0005
R61 VPWR VPWR.t0 258.204
R62 VPWR VPWR.t1 258.204
R63 VCCA VCCA.t0 825.715
R64 VCCA.t0 VCCA.t1 663.362
R65 VGND VGND.t1 214.005
R66 VGND VGND.t0 214.002
R67 GND GND.t1 3194.5
R68 GND.t1 GND.t0 2994.96
C0 Y A 1.12239f
C1 Y VPWR 0.07709f
C2 A VCCA 0.757456f
C3 VPWR VCCA 0.155613f
C4 VPWR A 0.741218f
C5 VGND Y 0.063634f
C6 VGND VCCA 0.004398f
C7 VGND A 0.648068f
C8 Y VCCA 0.006043f
C9 VGND VPWR 0.017143f
C10 VGND GND 1.988724f
C11 Y GND 1.392157f
C12 VPWR GND 2.33196f
C13 A GND 3.613513f
C14 VCCA GND 7.848316f
C15 VGND.t0 GND 0.250404f
C16 VGND.t1 GND 0.250403f
C17 VCCA.t1 GND 0.461883f
C18 VCCA.t0 GND 0.434851f
C19 VPWR.t1 GND 0.343875f
C20 VPWR.t0 GND 0.343875f
C21 Y.t1 GND 0.068241f
C22 Y.t3 GND 0.068241f
C23 Y.n0 GND 0.136483f
C24 Y.t0 GND 0.085302f
C25 Y.t2 GND 0.085302f
C26 Y.n1 GND 0.454874f
C27 Y.n2 GND 0.32761f
C28 A.n0 GND 0.02293f
C29 A.n1 GND 0.02293f
C30 A.t3 GND 0.539176f
C31 A.t1 GND 0.418465f
C32 A.n2 GND 0.968257f
C33 A.n3 GND 0.430339f
C34 A.n4 GND 0.440546f
C35 A.t0 GND 0.539176f
C36 A.t2 GND 0.418465f
C37 A.n5 GND 0.467186f
C38 A.n6 GND 0.029614f
C39 A.n7 GND 0.557696f
C40 A.n8 GND 0.489177f
C41 A.n9 GND 0.466777f
C42 A.n10 GND 0.087754f
C43 A.n11 GND 0.065812f
C44 A.n12 GND 0.082177f
C45 A.n13 GND 0.076476f
C46 A.n14 GND 0.09467f
C47 A.n15 GND 0.061198f
C48 A.n16 GND 0.011465f
C49 A.n17 GND 0.065011f
C50 A.n18 GND 0.025065f
C51 A.n19 GND 0.013906f
.ends
