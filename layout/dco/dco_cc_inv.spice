* SPICE3 file created from dco_cc_inv.ext - technology: sky130A

.subckt dco_cc_inv VCCA VPWR outp inp inn outn GND VGND
Xdco_aux_inv_0 VPWR VCCA outp outn GND VGND dco_aux_inv
Xdco_aux_inv_1 VPWR VCCA outn outp GND VGND dco_aux_inv
Xdco_main_inv_0 VPWR VCCA outp GND VGND inp dco_main_inv
Xdco_main_inv_1 VPWR VCCA outn GND VGND inn dco_main_inv
C0 VGND GND 2.28475f
C1 VCCA GND 7.56174f
.ends
