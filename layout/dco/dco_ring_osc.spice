* SPICE3 file created from dco_ring_osc.ext - technology: sky130A

.subckt dco_ring_osc VCCA GND VGND VPWR p[0] p[1] p[2] p[3] p[4] pn[0] pn[1] pn[2]
+ pn[3] pn[4]
C0 VPWR VCCA 6.423342f
Xdco_cc_inv_0 VCCA VPWR p[0] p[4] pn[4] pn[0] GND VGND dco_cc_inv
Xdco_cc_inv_1 VCCA VPWR p[1] p[0] pn[0] pn[1] GND VGND dco_cc_inv
Xdco_cc_inv_2 VCCA VPWR p[2] p[1] pn[1] pn[2] GND VGND dco_cc_inv
Xdco_cc_inv_3 VCCA VPWR p[4] p[3] pn[3] pn[4] GND VGND dco_cc_inv
Xdco_cc_inv_4 VCCA VPWR p[3] p[2] pn[2] pn[3] GND VGND dco_cc_inv
C1 pn[3] GND 2.738202f
C2 pn[4] GND 4.562163f
C3 VGND GND 11.993141f
C4 p[4] GND 4.744146f
C5 pn[2] GND 3.333182f
C6 VCCA GND 40.865208f
C7 p[2] GND 2.83106f
C8 pn[1] GND 2.738081f
C9 VPWR GND 8.496559f
C10 pn[0] GND 2.771663f
.ends
